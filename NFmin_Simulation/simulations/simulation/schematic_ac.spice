** sch_path: /media/sf_LNA_chipathon/The-Silent-Owl-GF180MCU-WB-LNA/Pads_Simulation/schematic_ac.sch
**.subckt schematic_ac
*  x1 -  gf180mcu_fd_io__asig_5p0  IS MISSING !!!!
V1 net1 0 dc 0 ac 1
V_VDD VDD 0 5
V_DVDD DVDD 0 5
R1 Vin net1 50 m=1
**** begin user architecture code

.control
save all
ac dec 1000 10e3 2e9
*sp lin 100 1e3 2e9 0
write ac_analog_pad.raw
.endc

.include /home/ttuser/pdk/gf180mcuD/libs.tech/ngspice/design.ngspice
.lib /home/ttuser/pdk/gf180mcuD/libs.tech/ngspice/sm141064.ngspice typical
.lib /home/ttuser/pdk/gf180mcuD/libs.tech/ngspice/sm141064.ngspice res_typical
.lib /home/ttuser/pdk/gf180mcuD/libs.tech/ngspice/sm141064.ngspice moscap_typical
.lib /home/ttuser/pdk/gf180mcuD/libs.tech/ngspice/sm141064.ngspice diode_typical
.include /foss/pdks/gf180mcuD/libs.ref/gf180mcu_fd_io/spice/gf180mcu_fd_io.spice

**** end user architecture code
**.ends
.end
