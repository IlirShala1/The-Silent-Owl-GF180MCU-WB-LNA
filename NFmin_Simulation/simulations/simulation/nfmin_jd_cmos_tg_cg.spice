** sch_path: /media/sf_LNA_chipathon/The-Silent-Owl-GF180MCU-WB-LNA/NFmin_Simulation/simulations/nfmin_jd_cmos_tg_cg.sch
**.subckt nfmin_jd_cmos_tg_cg
VGN_SRC ng GND {VGN}
VDD_SRC vdd GND {VDD}
COUT y out 10p m=1
CIN in x 10p m=1
XM2 y pg x vdd pfet_03v3 L={P_L} W={P_W} nf=1 ad='int((nf+1)/2) * W/nf * 0.18u' as='int((nf+2)/2) * W/nf * 0.18u' pd='2*int((nf+1)/2) * (W/nf + 0.18u)'
+ ps='2*int((nf+2)/2) * (W/nf + 0.18u)' nrd='0.18u / W' nrs='0.18u / W' sa=0 sb=0 sd=0 m=1
XM1 y ng x GND nfet_03v3 L={N_L} W={N_W} nf=1 ad='int((nf+1)/2) * W/nf * 0.18u' as='int((nf+2)/2) * W/nf * 0.18u' pd='2*int((nf+1)/2) * (W/nf + 0.18u)'
+ ps='2*int((nf+2)/2) * (W/nf + 0.18u)' nrd='0.18u / W' nrs='0.18u / W' sa=0 sb=0 sd=0 m=1
V1 in GND DC 0 AC 1 0 portnum 1 z0 50
V2 out GND DC 0 AC 1 0 portnum 2 z0 50
LIN x vinbias 10u m=1
VGP_SRC pg GND {VGP}
VINBIAS vinbias GND {VINCM}
VOUTBIAS voutbias GND {VOUTCM}
LOUT voutbias y 10u m=1
**** begin user architecture code

.include ../gf180mcu_pdk.inc
.include ../cmos_tg_cg_nfmin.spice

**** end user architecture code
**.ends
.GLOBAL GND
.end
