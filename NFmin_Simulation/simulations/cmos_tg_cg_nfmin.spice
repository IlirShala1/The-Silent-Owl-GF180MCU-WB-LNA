.option savecurrents

.param fnoicor=0
.param sw_stat_mismatch=0

.param VDD=1.8

.param VINCM=0.9
.param VOUTCM=0.9

.param VGN=1.3
.param VGP=0.5

.param N_W=1e-6
.param N_L=0.28e-6
.param P_W=1e-6
.param P_L=0.28e-6

.control
  set noaskquit
  save all

  echo "N_W_m N_L_m P_W_m P_L_m VCM VON VGN VGP VX_DC VY_DC VXY_DC IVINBIAS_A IVOUTBIAS_A IVDD_A IBIAS_EQ_A JD_EQ_mA_per_um" > cmos_tg_cg_jd_dense.txt
  echo "N_W_m N_L_m P_W_m P_L_m VCM VON VGN VGP NFmin_dB NF_dB Rn SOpt_real SOpt_imag" > cmos_tg_cg_nf_dense.txt

  foreach nwval 0.22e-6 1e-6 5e-6 10e-6

    foreach pwval 0.66e-6 2e-6 10e-6 20e-6

      foreach nlval 0.28e-6 0.36e-6 0.50e-6

        foreach plval 0.28e-6 0.36e-6 0.50e-6

          let vcm = 0.90
          let von = 0.35

          while von le 0.9001

            alterparam N_W = $nwval
            alterparam P_W = $pwval
            alterparam N_L = $nlval
            alterparam P_L = $plval

            alterparam VINCM = $&vcm
            alterparam VOUTCM = $&vcm

            let vgn_set = vcm + von
            let vgp_set = vcm - von

            alterparam VGN = $&vgn_set
            alterparam VGP = $&vgp_set

            reset

            op

            let vx_dc = v(x)
            let vy_dc = v(y)
            let vxy_dc = v(y) - v(x)

            let ivin = abs(i(vinbias))
            let ivout = abs(i(voutbias))
            let ivdd = abs(i(vdd_src))

            let ibias_eq = ivin + ivout + ivdd
            let jd_eq = 1e-3*ibias_eq/($nwval + $pwval)

            echo $nwval $nlval $pwval $plval $&vcm $&von $&vgn_set $&vgp_set $&vx_dc $&vy_dc $&vxy_dc $&ivin $&ivout $&ivdd $&ibias_eq $&jd_eq >> cmos_tg_cg_jd_dense.txt

            sp lin 1 2.4e9 2.4e9 1

            let nfmin_val = real(NFmin)
            let nf_val = real(NF)
            let rn_val = real(Rn)
            let sopt_re = real(SOpt)
            let sopt_im = imag(SOpt)

            echo $nwval $nlval $pwval $plval $&vcm $&von $&vgn_set $&vgp_set $&nfmin_val $&nf_val $&rn_val $&sopt_re $&sopt_im >> cmos_tg_cg_nf_dense.txt

            let von = von + 0.005

          end
        end
      end
    end
  end

.endc
