** sch_path: /media/sf_LNA_chipathon/The-Silent-Owl-GF180MCU-WB-LNA/NFmin_Simulation/simulations/nfmin_jd_pmos_cg.sch
**.subckt nfmin_jd_pmos_cg
VGG g GND {VG_BIAS}
VDDP_SRC vddp GND {VDDP}
LDD GND d 1u m=1
COUT d out 10p m=1
CIN in s 10p m=1
XM2 d g s vddp pfet_03v3 L={L} W={W} nf=1 ad='int((nf+1)/2) * W/nf * 0.18u' as='int((nf+2)/2) * W/nf * 0.18u' pd='2*int((nf+1)/2) * (W/nf + 0.18u)'
+ ps='2*int((nf+2)/2) * (W/nf + 0.18u)' nrd='0.18u / W' nrs='0.18u / W' sa=0 sb=0 sd=0 m=1
V1 in GND DC 0 AC 1 0 portnum 1 z0 50
V2 out GND DC 0 AC 1 0 portnum 2 z0 50
LSRC s vddp 10u m=1
**** begin user architecture code

.include ../gf180mcu_pdk.inc
.include ../pmos_nfmin_cg.spice

**** end user architecture code
**.ends
.GLOBAL GND
.end
